** Profile: "SCHEMATIC1-ac_analysis"  [ C:\Users\Public\Downloads\CAD\Filters-PSpiceFiles\SCHEMATIC1\ac_analysis.sim ]

** Creating circuit file "ac_analysis.cir"
** WARNING: THIS AUTOMATICALLY GENERATED FILE MAY BE OVERWRITTEN BY SUBSEQUENT SIMULATIONS

*Libraries:
* Profile Libraries :
* Local Libraries :
* From [PSPICE NETLIST] section of C:\Cadence\SPB_16.5\tools\PSpice\PSpice.ini file:
.lib "nomd.lib"

*Analysis directives:
.AC DEC 101 10 10000K
.PROBE V(alias(*)) I(alias(*)) W(alias(*)) D(alias(*)) NOISE(alias(*))
.INC "..\SCHEMATIC1.net"

.END
